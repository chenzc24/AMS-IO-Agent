libs = ddGetObj()
foreach(lib libs
    printf("%s\n" lib~>name)
)
