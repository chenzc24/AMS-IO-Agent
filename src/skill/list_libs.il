libs = ddGetObj()
while( libs
    println(libs~>name)
    libs = libs~>next
)
