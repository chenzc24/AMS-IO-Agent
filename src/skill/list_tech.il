techLibs = techGetTechFileList()
foreach(tech techLibs
    printf("Tech: %s\n" tech)
)
"Done"
